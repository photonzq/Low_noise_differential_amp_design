* Complete chain of the low-noise differential preamplifier note, front end H100, total gain 1000 (a3 1, a4 0.1, a5 0.2), filters off.
* S2 LM7171, S3/S4 THS4021, F1/F2 THS4031 followers (bypassed), S5 THS3091.  Section 4.5.
.options reltol=1e-4 abstol=1e-15 vntol=1e-9 gmin=1e-14 itl1=500 itl4=200
.options rshunt=1e12
.include "../sim/models/_lib/jfets.lib"
.include "../sim/models/_lib/opamps.lib"
.include "../sim/models/_lib/bjts.lib"
.model rnl r(noisy=0)
VIN ina 0 DC 0 AC 1
RIA ina ga 1m rnl
RIB 0 gb 1m rnl
* ===== front end H100: 2 x JFE2140 per side at 5 mA, R_F 500, R_G 10.1, gain 100
VP vp 0 DC 15
VM vm 0 DC -15
VREF vref0 0 DC 9
RREF vref0 vref 1k rnl
CREF vref 0 10u
BERR nerr 0 V=(V(oa)+V(ob)-V(sa)-V(sb))/2
GINT 0 nint nerr 0 1e-6
CINT nint 0 1u
RINT nint 0 1e12 rnl
BSNK vsink0 0 V=max(min(-12.34-V(nint), -10), -14)
RSNK vsink0 vsink 1k rnl
CSNK vsink 0 10u
* --- side a
XJa1 da1 ga sa JFE2140
XCa1 ca ba da1 LSBF862
XJa2 da2 ga sa JFE2140
XCa2 ca ba da2 LSBF862
RBSa ba sa 3500
CBSa ba sa 1e-06
RUPa vp ba 10900
RDa vp ca 600
CIa oa ca 9e-12
CXa ob ca 5e-12
CNa ca 0 2.2e-10
XUa vref ca oa vp vm OA_THS4021
RFa oa sa 500
QTa sa vsink ea MMBT3904
RTa ea vm 181.818
* --- side b
XJb1 db1 gb sb JFE2140
XCb1 cb bb db1 LSBF862
XJb2 db2 gb sb JFE2140
XCb2 cb bb db2 LSBF862
RBSb bb sb 3500
CBSb bb sb 1e-06
RUPb vp bb 10900
RDb vp cb 600
CIb ob cb 9e-12
CXb oa cb 5e-12
CNb cb 0 2.2e-10
XUb vref cb ob vp vm OA_THS4021
RFb ob sb 500
QTb sb vsink eb MMBT3904
RTb eb vm 181.818
RG sa sb 10.1
* input network (H)
CPA ga 0 1e-11
CPB gb 0 1e-11
RZA ga za 2200
CZA za 0 1e-11
RZB gb zb 2200
CZB zb 0 1e-11
RBA ga 0 1e+08
RBB gb 0 1e+08
* S2 difference amplifier (LM7171, gain 1)
RD1 ob dn 499
RD2 dn da 499
RD3 oa dp 499
RD4 dp 0 499
XS2 dp dn da vp vm OA_LM7171
* F1
RF1W da f1 1m rnl
* S3
RS3T f1 S3i 1 rnl
XS3 S3i S3n s3 vp vm OA_THS4021
RS3F s3 S3n 220
RS3G S3n 0 24.4
* F2
RF2W s3 f2 1m rnl
* S4
RS4T f2 S4t 224.1
RS4B S4t 0 24.9
RS4S S4t S4i 1
XS4 S4i S4n s4 vp vm OA_THS4021
RS4F s4 S4n 220
RS4G S4n 0 24.4
* S5 attenuator and output driver (THS3091, gain 5)
RS5T s4 s5t 199.2
RS5B s5t 0 49.8
RS5S s5t s5i 1
XS5 s5i s5n s5 vp vm OA_THS3091
RS5F s5 s5n 1k
RS5G s5n 0 250
RO50 s5 out 49.9
RLOAD out 0 1e+06
.control
set wr_singlescale
set wr_vecnames
op
print v(out)
ac dec 40 1 300meg
wrdata ac.txt v(out)
noise v(out) VIN dec 20 1 100meg
setplot noise2
print onoise_total
.endc
.end
