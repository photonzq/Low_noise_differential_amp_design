* SR560 front end, redrawn from SRS sheet 560_1F (manual Rev. 3.1), K102 at x10; NPD5564 as the
* recalibrated 2N5564 card; OP37 and LF411 behavioural.  Section 2.1 of the note.
.options reltol=1e-4 abstol=1e-15 vntol=1e-9 gmin=1e-14 itl1=500 itl4=200
.include "../sim/models/_lib/jfets.lib"
.subckt OP37 inp inn out vcc vee
Rnv nv 0 1
Vnv nv 0 0
Hnv inp ip1 Vnv 20.1795
Ifv 0 fv 1e-05
Dfv fv 0 dflk_v
Cfv fv fvs 1000
Vfv fvs 0 0
Hfv ip1 ip2 Vfv 837.956
.model dflk_v d(is=1e-14 n=1 kf=3.4607e-18 af=1)
Rnip nip 0 1
Vnip nip 0 0
Fnip 0 inp Vnip 0.0026906
Ifip 0 fip 1e-05
Dfip fip 0 dflk_ip
Cfip fip fisp 1000
Vfip fisp 0 0
Ffip 0 inp Vfip 0.111727
.model dflk_ip d(is=1e-14 n=1 kf=1.79444e-16 af=1)
Rnin nin 0 1
Vnin nin 0 0
Fnin 0 inn Vnin 0.0026906
Ifin 0 fin 1e-05
Dfin fin 0 dflk_in
Cfin fin fisn 1000
Vfin fisn 0 0
Ffin 0 inn Vfin 0.111727
.model dflk_in d(is=1e-14 n=1 kf=1.79444e-16 af=1)
Bg 0 n1 I=0.00017*tanh(0.00395841*(V(ip2)-V(inn))/0.00017)
R1 n1 0 4.54728e+08 rnl
C1 n1 0 1e-11
E2 n2 0 n1 0 1
R2 n2 n3 1 rnl
C2 n3 0 3.97887e-09
Bo no 0 V=min(max(V(n3), V(vee)+1.5), V(vcc)-1.5)
Ro no out 20 rnl
.model rnl r(noisy=0)
.ends OP37
.subckt LF411 inp inn out vcc vee
Rnv nv 0 1
Vnv nv 0 0
Hnv inp ip1 Vnv 168.163
Ifv 0 fv 1e-05
Dfv fv 0 dflk_v
Cfv fv fvs 1000
Vfv fvs 0 0
Hfv ip1 ip2 Vfv 6982.96
.model dflk_v d(is=1e-14 n=1 kf=1.28174e-16 af=1)
Rnip nip 0 1
Vnip nip 0 0
Fnip 0 inp Vnip 7.76711e-05
Rnin nin 0 1
Vnin nin 0 0
Fnin 0 inn Vnin 7.76711e-05
Bg 0 n1 I=0.00015*tanh(0.000251327*(V(ip2)-V(inn))/0.00015)
R1 n1 0 7.95775e+08 rnl
C1 n1 0 1e-11
E2 n3 0 n1 0 1
Bo no 0 V=min(max(V(n3), V(vee)+1.5), V(vcc)-1.5)
Ro no out 50 rnl
.model rnl r(noisy=0)
.ends LF411
.model rnl r(noisy=0)
VIN ina 0 DC 0 AC 1
VB inb 0 DC 0
* --- SR560 front end (schematic 560_1F) ---
R101 ina 0 100Meg
R102 inb 0 100Meg
XJA da ina sa 2N5564
XJB db inb sb 2N5564
R119 p10 vtop 165
C113 vtop 0 2.2u
R131 vtop da 499
R117 vtop db 499
R120 db 0 100k
C108 da 0 33p
R121 da ptrim 75k
VTRIM ptrim 0 DC 0
R113 sa xa 110
R115 xa ya 909
R135 ya tail 10
R114 sb xb 110
R128 xb yb 909
R137 yb tail 10
RP101A ya tail 50
RP101B yb tail 50
RK102 xa xb 1m rnl
R111 sa p102 1k
RP102 p102 0 10
R136 xa 0 100k
R112 sb fb 10
R118 fb out 1k
R116 out fo 499
C116 fo 0 150p
XU102 da db out p10 m10 OP37
C109 out db 33p
R129 da mid 100k
R127 db mid 100k
C110 mid tail 6.8p
VREF zref 0 DC 6.2
R125 zref ref 49.9k
C112 ref 0 0.1u
XU103 ref mid sv p10 m10 LF411
R130 tail sv 100
R122 sv m10 1k
VP p10 0 DC 10
VM m10 0 DC -10
.nodeset v(ref)=6.2 v(mid)=6.2 v(da)=6.2 v(db)=6.2 v(vtop)=8.5
.control
set wr_singlescale
set wr_vecnames
op
ac dec 40 1 100meg
wrdata ac.txt v(out)
noise v(out) VIN dec 20 1 10meg
setplot noise2
print onoise_total
.endc
.end
